// single_edge_sampler.va
// Author: Miguel Gandara
// samples a signal at either rising or falling edge of input clock
`include "constants.vams"
`include "disciplines.vams"
module single_edge_sampler(
  clk,
  vin,
  vout
);
  parameter direction = 1 from [-1:1] exclude 0;
  parameter real vdd = 1.2;
  parameter real tr = 100p;
  parameter real tf = 100p;
  parameter real td = 0;
  parameter integer file_io = 0 from [0:1];
  parameter string filename = "sampler.csv";
  parameter integer num_skip_points = 0;

  input clk; electrical clk;
  input [10:0] vin; electrical [10:0] vin;
  output [10:0] vout; electrical [10:0] vout;
  integer file;
  integer num_samples;

  real vout_real [10:0] ;

  analog begin
    @(initial_step) begin
      num_samples = 0;
      if (file_io) begin
        file = 0;
        file = $fopen(filename, "w");
        if (file == 0) begin
          $display("could not open file %s", filename);
          $finish(0);
        end
      end
    end

    @(cross(V(clk)-vdd/2,direction)) begin
        num_samples = num_samples + 1;
        vout_real[10] = V(vin[10]);
        vout_real[9]  = V(vin[9]);
        vout_real[8]  = V(vin[8]);
        vout_real[7]  = V(vin[7]);
        vout_real[6]  = V(vin[6]);
        vout_real[5]  = V(vin[5]);
        vout_real[4]  = V(vin[4]);
        vout_real[3]  = V(vin[3]);
        vout_real[2]  = V(vin[2]);
        vout_real[1]  = V(vin[1]);
        vout_real[0]  = V(vin[0]);

        if ((num_samples > num_skip_points) && file_io) begin
            $fwrite(file,
                "%g,%g,%g,%g,%g,%g,%g,%g,%g,%g,%g,%g\n",
                $abstime,
                vout_real[10], vout_real[9], vout_real[8], vout_real[7],
                vout_real[6], vout_real[5], vout_real[4], vout_real[3],
                vout_real[2], vout_real[1], vout_real[0]
            );
        end
    end

    V(vout[10]) <+ transition(vout_real[10], td, tr, tf);
    V(vout[9])  <+ transition(vout_real[9],  td, tr, tf);
    V(vout[8])  <+ transition(vout_real[8],  td, tr, tf);
    V(vout[7])  <+ transition(vout_real[7],  td, tr, tf);
    V(vout[6])  <+ transition(vout_real[6],  td, tr, tf);
    V(vout[5])  <+ transition(vout_real[5],  td, tr, tf);
    V(vout[4])  <+ transition(vout_real[4],  td, tr, tf);
    V(vout[3])  <+ transition(vout_real[3],  td, tr, tf);
    V(vout[2])  <+ transition(vout_real[2],  td, tr, tf);
    V(vout[1])  <+ transition(vout_real[1],  td, tr, tf);
    V(vout[0])  <+ transition(vout_real[0],  td, tr, tf);

    @(final_step) begin
      if (file_io) begin
        $fclose(file);
      end
    end
  end

endmodule
