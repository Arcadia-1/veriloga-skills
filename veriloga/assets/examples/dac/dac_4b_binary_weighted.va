`include "constants.vams"
`include "disciplines.vams"

`define NUM_ADC_BITS 4
`default_transition 30p

module _va_dac_4b_se(input electrical[`NUM_ADC_BITS-1:0] DIN,input electrical RDY,output electrical AOUT);

real weight[`NUM_ADC_BITS-1:0] = {4, 2, 1, 0.5};
real sum;

parameter real vdd = 1, vth = 0.5;

real aout;
integer init_i;

analog begin
	//reset
	@(initial_step) begin
		sum = 0;
		for(init_i = `NUM_ADC_BITS-1; init_i >= 0; init_i = init_i-1) begin
			sum = sum + weight[init_i];
		end
	end

	//update when data (digital output code of ADC) is ready
	@(cross(V(RDY)-vth,+1)) begin
		aout = 0;
		if (V(DIN[0]) > vth) aout = aout + weight[0];
		if (V(DIN[1]) > vth) aout = aout + weight[1];
		if (V(DIN[2]) > vth) aout = aout + weight[2];
		if (V(DIN[3]) > vth) aout = aout + weight[3];
		aout = (aout/sum*2-1) * vdd;
	end
	V(AOUT) <+ transition(aout,0);
end

endmodule
