// Correct Example: Edge Detector
// Demonstrates proper edge detection patterns

module edge_detector (
    inout electrical VDD,
    inout electrical VSS,
    input electrical signal_i,
    output electrical rising_o,
    output electrical falling_o
);
    // All variables at module level
    parameter real vth = 0.5;
    parameter real pulse_width = 10n;
    integer rising_pulse, falling_pulse;
    real vh_actual, vl_actual;

    analog begin
        // Read supply voltages
        vh_actual = V(VDD);
        vl_actual = V(VSS);

        // Initialize pulse counters
        @(initial_step) begin
            rising_pulse = 0;
            falling_pulse = 0;
        end

        // Detect rising edge (+1 direction)
        @(cross(V(signal_i) - vth, +1)) begin
            rising_pulse = 1;
        end

        // Detect falling edge (-1 direction)
        @(cross(V(signal_i) - vth, -1)) begin
            falling_pulse = 1;
        end

        // Reset pulse flags after delay
        @(timer(0, pulse_width)) begin
            rising_pulse = 0;
            falling_pulse = 0;
        end

        // Output pulses
        V(rising_o) <+ transition(rising_pulse ? vh_actual : vl_actual);
        V(falling_o) <+ transition(falling_pulse ? vh_actual : vl_actual);
    end
endmodule
