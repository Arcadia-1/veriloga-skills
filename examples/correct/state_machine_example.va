// Complete Reference Example: State Machine with Multiple Outputs
// Demonstrates all key Verilog-A guidelines in a single module

module state_machine_example (
    // Power ports - always inout
    inout electrical VDD,
    inout electrical VSS,

    // Input signals
    input electrical clk_i,
    input electrical reset_i,
    input electrical start_i,
    input electrical [3:0] config_i,

    // Output signals
    output electrical busy_o,
    output electrical done_o,
    output electrical [7:0] result_o
);
    // ============================================
    // ALL VARIABLE DECLARATIONS AT MODULE LEVEL
    // ============================================

    // Parameters
    parameter real vth = 0.5;           // Threshold voltage
    parameter real tdelay = 1n;         // Output delay

    // State encoding
    parameter integer IDLE = 0;
    parameter integer LOAD = 1;
    parameter integer PROCESS = 2;
    parameter integer DONE = 3;

    // Integer variables
    integer state, next_state;
    integer clk_val, reset_val, start_val;
    integer config_val;
    integer counter, result_val;
    integer busy_val, done_val;

    // Real variables for supply voltages
    real vh_actual, vl_actual;

    // Loop variables - use genvar!
    genvar i;

    // ============================================
    // ANALOG BLOCK
    // ============================================

    analog begin
        // ----------------------------------------
        // Read supply voltages
        // ----------------------------------------
        vh_actual = V(VDD);
        vl_actual = V(VSS);

        // ----------------------------------------
        // Initialize state variables
        // ----------------------------------------
        @(initial_step) begin
            state = IDLE;
            next_state = IDLE;
            counter = 0;
            result_val = 0;
            busy_val = 0;
            done_val = 0;
        end

        // ----------------------------------------
        // Read input signals
        // ----------------------------------------
        clk_val = (V(clk_i) > vth) ? 1 : 0;
        reset_val = (V(reset_i) > vth) ? 1 : 0;
        start_val = (V(start_i) > vth) ? 1 : 0;

        // Read configuration bus
        config_val = 0;
        for (i = 0; i < 4; i = i + 1) begin
            if (V(config_i[i]) > vth)
                config_val = config_val | (1 << i);
        end

        // ----------------------------------------
        // Synchronous reset
        // ----------------------------------------
        if (reset_val) begin
            next_state = IDLE;
            counter = 0;
            result_val = 0;
        end

        // ----------------------------------------
        // State machine logic (combinational)
        // ----------------------------------------
        case (state)
            IDLE: begin
                busy_val = 0;
                done_val = 0;
                if (start_val && !reset_val)
                    next_state = LOAD;
                else
                    next_state = IDLE;
            end

            LOAD: begin
                busy_val = 1;
                done_val = 0;
                result_val = config_val;
                next_state = PROCESS;
            end

            PROCESS: begin
                busy_val = 1;
                done_val = 0;
                result_val = result_val + counter;
                if (counter >= 10)
                    next_state = DONE;
                else
                    next_state = PROCESS;
            end

            DONE: begin
                busy_val = 0;
                done_val = 1;
                next_state = IDLE;
            end

            default: begin
                next_state = IDLE;
            end
        endcase

        // ----------------------------------------
        // Clock edge detection (rising edge)
        // ----------------------------------------
        @(cross(V(clk_i) - vth, +1)) begin
            if (!reset_val) begin
                // Update state on clock edge
                state = next_state;

                // Update counter in PROCESS state
                if (state == PROCESS) begin
                    counter = counter + 1;
                end else begin
                    counter = 0;
                end
            end
        end

        // ----------------------------------------
        // Output assignments
        // ----------------------------------------

        // Single bit outputs
        V(busy_o) <+ transition(busy_val ? vh_actual : vl_actual, 0, tdelay);
        V(done_o) <+ transition(done_val ? vh_actual : vl_actual, 0, tdelay);

        // Bus output (8-bit result)
        for (i = 0; i < 8; i = i + 1) begin
            V(result_o[i]) <+ transition(
                (result_val & (1 << i)) ? vh_actual : vl_actual,
                0,
                tdelay
            );
        end
    end

endmodule

/*
 * GUIDELINES DEMONSTRATED IN THIS MODULE:
 *
 * 1. Power Ports: VDD/VSS declared as 'inout electrical'
 * 2. Signal Types: All signals use 'electrical' type
 * 3. Variable Declarations: ALL variables declared at module level (before analog begin)
 * 4. Loop Variables: 'genvar i' used for all for loops (not integer)
 * 5. Initialization: All state variables initialized with @(initial_step)
 * 6. Supply Voltage: Actual VDD/VSS voltages read and used
 * 7. Input Reading: Threshold comparison used for digital inputs
 * 8. Output Writing: transition() used with actual supply voltages
 * 9. Edge Detection: @(cross(V(clk_i) - vth, +1)) for rising edge
 * 10. No SystemVerilog: Pure Verilog-A constructs only
 *
 * KEY POINTS:
 * - All variables (state, counter, config_val, etc.) at module level
 * - genvar i used for loops, not integer
 * - VDD/VSS are inout, not input
 * - Supply voltages vh_actual/vl_actual read from VDD/VSS
 * - @(cross()) with +1 for rising edge
 * - @(initial_step) for initialization
 * - transition() with literal delay (1n), not macro
 */
