// Correct Example: Simple Buffer with Supply Voltage Tracking
// Demonstrates proper power port usage

module buffer (
    inout electrical VDD,
    inout electrical VSS,
    input electrical in_i,
    output electrical out_o
);
    // All variables declared at module level
    parameter real vth = 0.5;
    parameter real tdelay = 1n;
    integer in_val;
    real vh_actual, vl_actual;

    analog begin
        // Always read actual supply voltages
        vh_actual = V(VDD);
        vl_actual = V(VSS);

        // Read input value
        in_val = (V(in_i) > vth) ? 1 : 0;

        // Drive output with actual supply voltages
        V(out_o) <+ transition(in_val ? vh_actual : vl_actual, 0, tdelay);
    end
endmodule
