// INCORRECT Example: Uninitialized Variables
// This demonstrates WRONG usage - state variables must be initialized

module counter_uninitialized (
    inout electrical VDD,
    inout electrical VSS,
    input electrical clk_i,
    output electrical [7:0] count_o
);
    parameter real vth = 0.5;
    integer count;  // ❌ ERROR: Not initialized!
    real vh_actual, vl_actual;
    genvar i;

    analog begin
        vh_actual = V(VDD);
        vl_actual = V(VSS);

        // ❌ ERROR: Missing initialization!
        // count is never initialized, will have undefined value

        @(cross(V(clk_i) - vth, +1)) begin
            count = count + 1;  // Using uninitialized 'count'!
        end

        for (i = 0; i < 8; i = i + 1) begin
            V(count_o[i]) <+ transition((count & (1 << i)) ? vh_actual : vl_actual);
        end
    end
endmodule

// CORRECT VERSION: Always initialize state variables
/*
module counter_initialized (
    inout electrical VDD,
    inout electrical VSS,
    input electrical clk_i,
    output electrical [7:0] count_o
);
    parameter real vth = 0.5;
    integer count;
    real vh_actual, vl_actual;
    genvar i;

    analog begin
        vh_actual = V(VDD);
        vl_actual = V(VSS);

        // ✓ Correct: Initialize at simulation start
        @(initial_step) begin
            count = 0;
        end

        @(cross(V(clk_i) - vth, +1)) begin
            count = count + 1;
        end

        for (i = 0; i < 8; i = i + 1) begin
            V(count_o[i]) <+ transition((count & (1 << i)) ? vh_actual : vl_actual);
        end
    end
endmodule
*/
