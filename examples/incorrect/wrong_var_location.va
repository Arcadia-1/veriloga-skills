// INCORRECT Example: Variables Declared Inside analog begin
// This demonstrates WRONG usage - variables MUST be declared at module level

module counter_wrong_vars (
    inout electrical VDD,
    inout electrical VSS,
    input electrical clk_i,
    output electrical [7:0] count_o
);
    // Some variables at module level
    parameter real vth = 0.5;
    genvar i;

    analog begin
        // ❌ ERROR: Variables declared inside analog block!
        // This is WRONG - all variables must be declared at module level
        integer count;  // ERROR!
        integer clk_val;  // ERROR!
        real vh_actual, vl_actual;  // ERROR!

        vh_actual = V(VDD);
        vl_actual = V(VSS);

        @(initial_step) count = 0;

        clk_val = (V(clk_i) > vth) ? 1 : 0;

        @(cross(V(clk_i) - vth, +1)) begin
            count = count + 1;
        end

        for (i = 0; i < 8; i = i + 1) begin
            V(count_o[i]) <+ transition((count & (1 << i)) ? vh_actual : vl_actual);
        end
    end
endmodule

// CORRECT VERSION: All variables declared at module level
/*
module counter_correct (
    inout electrical VDD,
    inout electrical VSS,
    input electrical clk_i,
    output electrical [7:0] count_o
);
    parameter real vth = 0.5;
    integer count, clk_val;  // ✓ At module level
    real vh_actual, vl_actual;  // ✓ At module level
    genvar i;

    analog begin
        // Only assignments and logic here
        vh_actual = V(VDD);
        vl_actual = V(VSS);
        // ... rest of code
    end
endmodule
*/
