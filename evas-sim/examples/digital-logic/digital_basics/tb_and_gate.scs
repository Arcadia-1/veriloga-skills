// tb_and_gate.scs — AND gate truth-table sweep
// Input sequence (A,B): (0,0)→(0,1)→(1,0)→(1,1), 2 ns per state
//   t=0..2n   A=0 B=0 → out=0
//   t=2..4n   A=0 B=1 → out=0
//   t=4..6n   A=1 B=0 → out=0
//   t=6..8n   A=1 B=1 → out=1
simulator lang=spectre
global 0

ahdl_include "and_gate.va"

// A: low until 4 ns, then high  (30 ps edge)
VA (a 0) vsource type=pwl wave=[0 0  3.985n 0  4.015n 0.8  8n 0.8]

// B: toggles every 2 ns  (30 ps edges)
VB (b 0) vsource type=pwl wave=[0 0  1.985n 0  2.015n 0.8 \
                                 3.985n 0.8  4.015n 0 \
                                 5.985n 0    6.015n 0.8  8n 0.8]

IDUT (a b y) and_gate

tran tran stop=8n maxstep=0.1n
save a:2e b:2e y:2e
