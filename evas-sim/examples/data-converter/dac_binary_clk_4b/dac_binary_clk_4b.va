// DAC_4B: 4-bit binary-weighted DAC
// VerilogA model: converts 4-bit digital code to analog voltage
// Transfer: AOUT = (code / 16) * vref, where code = 8*D3 + 4*D2 + 2*D1 + D0

`include "constants.vams"
`include "disciplines.vams"

module dac_binary_clk_4b(
    input  electrical DIN3,
    input  electrical DIN2,
    input  electrical DIN1,
    input  electrical DIN0,
    input  electrical CLK,
    output electrical AOUT
);

parameter real vref = 0.9;
parameter real vth  = 0.45;

real aout;

analog begin
    @(initial_step) begin
        aout = 0.0;
        $strobe("[dac_binary_clk_4b] INIT | vref=%.3gV | vth=%.3gV", vref, vth);
    end

    @(cross(V(CLK) - vth, +1)) begin
        aout = ((V(DIN3) > vth) * 8
              + (V(DIN2) > vth) * 4
              + (V(DIN1) > vth) * 2
              + (V(DIN0) > vth) * 1) / 16.0 * vref;
        $strobe("[dac_binary_clk_4b] t=%.3f ns | aout=%.5gV", $abstime*1e9, aout);
    end

    V(AOUT) <+ transition(aout, 0, 100p, 100p);
end

endmodule
