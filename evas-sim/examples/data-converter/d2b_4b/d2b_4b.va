`include "constants.vams"
`include "disciplines.vams"

module d2b_4b (bin_o, bin_n_o, onehot_o, onehot_n_o, therm_o, therm_n_o);

output [3:0]  bin_o;
output [3:0]  bin_n_o;
output [15:0] onehot_o;
output [15:0] onehot_n_o;
output [14:0] therm_o;
output [14:0] therm_n_o;

electrical [3:0]  bin_o;
electrical [3:0]  bin_n_o;
electrical [15:0] onehot_o;
electrical [15:0] onehot_n_o;
electrical [14:0] therm_o;
electrical [14:0] therm_n_o;

parameter integer trim_code = 7;   // 0..15
parameter real    vdd       = 0.9;
parameter real    tr        = 10p;

integer bin_bits[3:0];
integer bin_n_bits[3:0];
integer onehot_bits[15:0];
integer onehot_n_bits[15:0];
integer therm_bits[14:0];
integer therm_n_bits[14:0];
integer n;
integer init_k;
genvar  k;

analog begin
    @(initial_step) begin
        n = (trim_code < 0) ? 0 : ((trim_code > 15) ? 15 : trim_code);

        for (init_k = 0; init_k < 4; init_k = init_k + 1) begin
            bin_bits[init_k]   = (n >> init_k) & 1;
            bin_n_bits[init_k] = 1 - bin_bits[init_k];
        end

        for (init_k = 0; init_k < 16; init_k = init_k + 1) begin
            onehot_bits[init_k]   = (init_k == n) ? 1 : 0;
            onehot_n_bits[init_k] = (init_k == n) ? 0 : 1;
        end

        for (init_k = 0; init_k < 15; init_k = init_k + 1) begin
            therm_bits[init_k]   = (init_k < n) ? 1 : 0;
            therm_n_bits[init_k] = (init_k < n) ? 0 : 1;
        end

        $strobe("[d2b_4b] INIT | trim_code=%d | n=%d | bin[3:0]=%d%d%d%d | onehot[15:0]=%d%d%d%d%d%d%d%d%d%d%d%d%d%d%d%d | therm[14:0]=%d%d%d%d%d%d%d%d%d%d%d%d%d%d%d",
            trim_code, n,
            bin_bits[3],   bin_bits[2],   bin_bits[1],   bin_bits[0],
            onehot_bits[15], onehot_bits[14], onehot_bits[13], onehot_bits[12],
            onehot_bits[11], onehot_bits[10], onehot_bits[9],  onehot_bits[8],
            onehot_bits[7],  onehot_bits[6],  onehot_bits[5],  onehot_bits[4],
            onehot_bits[3],  onehot_bits[2],  onehot_bits[1],  onehot_bits[0],
            therm_bits[14], therm_bits[13], therm_bits[12], therm_bits[11],
            therm_bits[10], therm_bits[9],  therm_bits[8],  therm_bits[7],
            therm_bits[6],  therm_bits[5],  therm_bits[4],  therm_bits[3],
            therm_bits[2],  therm_bits[1],  therm_bits[0]);
    end

    for (k = 0; k < 4; k = k + 1) begin
        V(bin_o[k])   <+ transition(bin_bits[k]   ? vdd : 0, 0, tr, tr);
        V(bin_n_o[k]) <+ transition(bin_n_bits[k] ? vdd : 0, 0, tr, tr);
    end

    for (k = 0; k < 16; k = k + 1) begin
        V(onehot_o[k])   <+ transition(onehot_bits[k]   ? vdd : 0, 0, tr, tr);
        V(onehot_n_o[k]) <+ transition(onehot_n_bits[k] ? vdd : 0, 0, tr, tr);
    end

    for (k = 0; k < 15; k = k + 1) begin
        V(therm_o[k])   <+ transition(therm_bits[k]   ? vdd : 0, 0, tr, tr);
        V(therm_n_o[k]) <+ transition(therm_n_bits[k] ? vdd : 0, 0, tr, tr);
    end
end

endmodule
