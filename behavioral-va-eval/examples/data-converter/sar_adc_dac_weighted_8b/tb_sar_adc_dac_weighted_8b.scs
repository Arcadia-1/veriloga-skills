// sar_adc_dac_weighted_8b: 8-bit binary-weighted SAR ADC → DAC round-trip
//
// ADC samples vin at fs = 500 MHz (period = 2 ns).
// Input: near-full-swing sine at fin = 1 MHz → 500 samples/cycle × 20 cycles.
// DAC reconstructs combinatorially; vout shows the 256-level staircase.
//
// Weights (MSB→LSB): 128, 64, 32, 16, 8, 4, 2, 1  (total = 255).
// LSB step = vdd / 255 ≈ 3.5 mV  (@vdd = 0.9 V).
//
// RST_N: active-low reset, held low for the first 10 clock cycles (20 ns).
// First 20 ns of data is excluded from error / INL / DNL analysis.
//
simulator lang=spectre
global 0

ahdl_include "sar_adc_weighted_8b.va"
ahdl_include "dac_weighted_8b.va"
ahdl_include "sh_ideal.va"

parameters vdd=0.9 fs=500e6 fin=1e6

// Supply rails
Vvdd (vdd 0) vsource dc=vdd
Vvss (vss 0) vsource dc=0

// Sampling clock: 500 MHz  (period = 2 ns)
Vclks (clks 0) vsource type=pulse val0=0 val1=vdd period=2n \
               rise=100p fall=100p

// Reset: active-low for first 10 clock cycles (0 → 20 ns), then deassert
Vrst_n (rst_n 0) vsource type=pwl wave=[0 0  19.5n 0  20n vdd  20020n vdd]

// Input: full-swing sine, 20 cycles at 1 MHz
// offset = vdd/2 = 0.45 V,  ampl = vdd/2 = 0.45 V  →  range [0, vdd]
Vvin (vin 0) vsource type=sine sinedc=0.45 ampl=0.45 freq=fin

// ADC: VIN CLKS RST_N → DOUT[7:0]  (dout_7=MSB, dout_0=LSB)
IADC (vin clks rst_n dout_7 dout_6 dout_5 dout_4 dout_3 dout_2 dout_1 dout_0) \
      sar_adc_weighted_8b vdd=vdd

// DAC: DIN[7:0] → VOUT  (combinatorial reconstruction)
IDAC (dout_7 dout_6 dout_5 dout_4 dout_3 dout_2 dout_1 dout_0 vout) \
      dac_weighted_8b vdd=vdd

// S&H: samples vin on same rising clks edge as ADC → vin_sh
ISH (vin clks vdd vss rst_n vin_sh) sh_ideal

tran tran stop=20u maxstep=500p
save vin:3f vin_sh:3f clks:2e rst_n:d vout:3f dout_7:d dout_6:d dout_5:d dout_4:d dout_3:d dout_2:d dout_1:d dout_0:d
