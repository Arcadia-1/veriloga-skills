`include "constants.vams"
`include "disciplines.vams"

`default_transition 10p

// DWA pointer rotation generator — MSB-only (no overlap).
// Identical to dwa_ptr_gen except cell_en selects exactly `code` cells
// per cycle: cells [old_ptr, new_ptr-1] (new_ptr itself is NOT included).
// Consecutive cycles share no boundary cell (首尾不重叠).

module dwa_ptr_gen_no_overlap (
    input  electrical        clk_i,
    input  electrical        rst_ni,
    input  electrical [3:0]  code_msb_i,
    output electrical [15:0] cell_en_o,
    output electrical [15:0] ptr_o
);

parameter real    vdd      = 0.9;
parameter real    vth      = 0.45;
parameter integer ptr_init = 0;

integer start_idx_q;
integer msb_count_q;
integer lsb_idx;
integer dist;
integer j;
genvar  i;

real cell_en_val[15:0];
real ptr_val[15:0];

analog begin
    @(initial_step) begin
        start_idx_q = ptr_init;
        msb_count_q = 0;
        for (j = 0; j < 16; j = j + 1) begin
            cell_en_val[j] = 0.0;
            ptr_val[j] = 0.0;
        end
    end

    @(cross(V(clk_i) - vth, +1)) begin
        if (V(rst_ni) < vth) begin
            start_idx_q = ptr_init;
            msb_count_q = 0;
        end else begin
            msb_count_q = 0;
            if (V(code_msb_i[0]) > vth) msb_count_q = msb_count_q + 1;
            if (V(code_msb_i[1]) > vth) msb_count_q = msb_count_q + 2;
            if (V(code_msb_i[2]) > vth) msb_count_q = msb_count_q + 4;
            if (V(code_msb_i[3]) > vth) msb_count_q = msb_count_q + 8;

            start_idx_q = (start_idx_q + msb_count_q) % 16;
        end

        // lsb_idx = old pointer = start of the selected range
        lsb_idx = (start_idx_q - msb_count_q + 16) % 16;

        for (j = 0; j < 16; j = j + 1) begin
            dist = (start_idx_q - j + 16) % 16;
            // No-overlap: select cells where 0 < dist <= msb_count_q
            // (dist=0 is the new ptr itself — excluded from current cycle)
            cell_en_val[j] = ((dist > 0) && (dist <= msb_count_q)) ? vdd : 0.0;
            ptr_val[j] = (j == start_idx_q) ? vdd : 0.0;
        end
        $strobe("[dwa_ptr_gen_no_overlap] t=%.3f ns | ptr=%2d | msb=%2d | lsb=%2d | cell=%0d%0d%0d%0d%0d%0d%0d%0d%0d%0d%0d%0d%0d%0d%0d%0d",
            $abstime*1e9, start_idx_q, msb_count_q, lsb_idx,
            (cell_en_val[15]>vth?1:0),(cell_en_val[14]>vth?1:0),(cell_en_val[13]>vth?1:0),(cell_en_val[12]>vth?1:0),
            (cell_en_val[11]>vth?1:0),(cell_en_val[10]>vth?1:0),(cell_en_val[9]>vth?1:0),(cell_en_val[8]>vth?1:0),
            (cell_en_val[7]>vth?1:0),(cell_en_val[6]>vth?1:0),(cell_en_val[5]>vth?1:0),(cell_en_val[4]>vth?1:0),
            (cell_en_val[3]>vth?1:0),(cell_en_val[2]>vth?1:0),(cell_en_val[1]>vth?1:0),(cell_en_val[0]>vth?1:0));
    end

    for (i = 0; i < 16; i = i + 1) begin
        V(cell_en_o[i]) <+ transition(cell_en_val[i]);
        V(ptr_o[i])     <+ transition(ptr_val[i]);
    end
end

endmodule
